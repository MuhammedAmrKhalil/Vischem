global 0
simulator lang=spectre

include "$ADT_LUT/design.ngspice"
include "$ADT_LUT/sm141064.ngspice" section=typical

parameters

subckt test AVDD AGND VINP VOUT

M2a (net03 net03 AVDD AVDD) pmos_03v3 L=660n W=28.7u nf=8 ad=int((8+1)/2) * 28.7u/8 * 0.18u as=int((8+2)/2) * 28.7u/8 * 0.18u pd=2*int((8+1)/2) * (28.7u/8 + 0.18u) ps=2*int((8+2)/2) * (28.7u/8 + 0.18u) nrd=0.18u / 28.7u nrs=0.18u / 28.7u sa=0 sb=0 sd=0 multi=4
M2b (VOUT net03 AVDD AVDD) pmos_03v3 L=660n W=28.7u nf=8 ad=int((8+1)/2) * 28.7u/8 * 0.18u as=int((8+2)/2) * 28.7u/8 * 0.18u pd=2*int((8+1)/2) * (28.7u/8 + 0.18u) ps=2*int((8+2)/2) * (28.7u/8 + 0.18u) nrd=0.18u / 28.7u nrs=0.18u / 28.7u sa=0 sb=0 sd=0 multi=4
S1vbn_AC (Vbn AGND) switch position=0 dc_position=0 ac_position=1 tran_position=0 ic_position=0
I1_VBN (AVDD Vbn) isource dc=0.0001 type=dc
C1OUT (VOUT AGND) capacitor c=1p
M1vbn (Vbn Vbn AGND AGND) nmos_03v3 L=1.18u W=30.8u nf=8 ad=int((8+1)/2) * 30.86u/8 * 0.18u as=int((8+2)/2) * 30.86u/8 * 0.18u pd=2*int((8+1)/2) * (30.86u/8 + 0.18u) ps=2*int((8+2)/2) * (30.86u/8 + 0.18u) nrd=0.18u / 30.86u nrs=0.18u / 30.86u sa=0 sb=0 sd=0 multi=6
M3 (net18 Vbn AGND AGND) nmos_03v3 L=1.18u W=30.8u nf=8 ad=int((8+1)/2) * 30.85u/8 * 0.18u as=int((8+2)/2) * 30.85u/8 * 0.18u pd=2*int((8+1)/2) * (30.85u/8 + 0.18u) ps=2*int((8+2)/2) * (30.85u/8 + 0.18u) nrd=0.18u / 30.85u nrs=0.18u / 30.85u sa=0 sb=0 sd=0 multi=6
M1b (VOUT VOUT net18 AGND) nmos_03v3 L=350n W=26.3u nf=8 ad=int((8+1)/2) * 26.3u/8 * 0.18u as=int((8+2)/2) * 26.3u/8 * 0.18u pd=2*int((8+1)/2) * (26.3u/8 + 0.18u) ps=2*int((8+2)/2) * (26.3u/8 + 0.18u) nrd=0.18u / 26.3u nrs=0.18u / 26.3u sa=0 sb=0 sd=0 multi=2
M1a (net03 VINP net18 AGND) nmos_03v3 L=350n W=26.3u nf=8 ad=int((8+1)/2) * 26.3u/8 * 0.18u as=int((8+2)/2) * 26.3u/8 * 0.18u pd=2*int((8+1)/2) * (26.3u/8 + 0.18u) ps=2*int((8+2)/2) * (26.3u/8 + 0.18u) nrd=0.18u / 26.3u nrs=0.18u / 26.3u sa=0 sb=0 sd=0 multi=2
ends test
I1 (AVDD 0 VINP VOUT) test
V1 (VINP 0) vsource dc=1.2 type=dc
V0 (AVDD 0) vsource dc=1.8 type=dc

simulatorOptions options psfversion="1.4.0" reltol=1e-3 vabstol=1e-6 iabstol=1e-12 temp=27 tnom=27 scalem=1.0 scale=1.0 gmin=1e-12 rforce=1 maxnotes=5 maxwarns=5 digits=5 cols=80 pivrel=1e-3 sensfile="../psf/sens.output" dochecklimit=yes checklimitdest=psf

dcOpCheckLimit checklimit checkallasserts=yes severity=none
dcOp dc maxiters=150 maxsteps=10000 annotate=status
modelParameter info what=models where=rawfile
element info what=inst where=rawfile
outputParameter info what=output where=rawfile
designParamVals info what=parameters where=rawfile
primitives info what=primitives where=rawfile
subckts info what=subckts where=rawfile
asserts info what=assert where=rawfile
saveOptions options save=allpub
save*:oppoint sigtype=dev
