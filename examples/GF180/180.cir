* Vischem
* Generated by Vischem v0.1 — NGspice ready
*
* ── Models ──────────────────────────────────────────────────────────
* ── GlobalFoundries 180nm (GF180MCU) Models ──────────────────────────
.include "/home/ziad/pdk/gf180mcuD/libs.tech/ngspice/design.ngspice"
.lib "/home/ziad/pdk/gf180mcuD/libs.tech/ngspice/sm141064.ngspice" typical
*
* ── Netlist ──
XM1        N002     N001     0        0      nfet_03v3  W=2u L=0.28u
V1         N001     0        DC 1
V2         N002     0        DC 1
*
* ── Simulation ──────────────────────────────────────────────────────
* Active: TRAN  →  180.raw
.control
tran 1n 1u 0
write 180.raw
quit
.endc
*
* Other analyses (uncomment to use):
* .op ...
* .dc ...
* .ac ...
* .noise ...
*
.end
