* 180
* Generated by Vischem v0.1 — NGspice ready
*
* ── Models ──────────────────────────────────────────────────────────
.include "C:/Users/mamr2/OneDrive/Desktop/sm141064.ngspice"
*
* ── Netlist ──
M1         N002     N001     0        0      nfet_03v3.0  W=2u L=180n
V1         N001     0        DC 1
V2         N002     0        DC 1
*
* ── Simulation ──────────────────────────────────────────────────────
* Active: TRAN  →  180.raw
.control
tran 1n 1u 0
write 180.raw
quit
.endc
*
* Other analyses (uncomment to use):
* .op ...
* .dc ...
* .ac ...
* .noise ...
*
.end
