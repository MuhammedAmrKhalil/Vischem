* CS_amp
* Generated by Vischem v0.1 — NGspice ready
*
* ── Models ──────────────────────────────────────────────────────────
.include "C:/Users/mamr2/OneDrive/Desktop/vischem/examples/models/cmosedu_models.lib"
*
* ── Netlist ──
M1         out      in       0        0      N_p5u  W=222u L=1000n
V2         in       0        DC 0.75 AC 1 SIN(0.75 1m 1k 0 0 0)
R2         N001     out      50k
C1         out      0        1p
V4         N001     0        DC 5
*
* ── Simulation ──────────────────────────────────────────────────────
* Active: AC  →  CS_amp.raw
.control
ac dec 10 1 10G
write CS_amp.raw
quit
.endc
*
* Other analyses (uncomment to use):
* .op ...
* .dc ...
* .tran ...
* .noise ...
*
.end
