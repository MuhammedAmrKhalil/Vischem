* Vischem
* Generated by Vischem v0.1 — NGspice ready
*
* ── Models ──────────────────────────────────────────────────────────
* ── SkyWater 130nm (sky130A) Models ──────────────────────────
.lib "/home/ziad/pdk/sky130A/libs.tech/ngspice/sky130.lib.spice" tt
*
* ── Netlist ──
Vdd        N002     0        DC 1
Vin        N001     0        DC 1
XM1        N003     N001     N002     VDD    sky130_fd_pr__pfet_01v8  W=2 L=0.15
XM2        N003     N001     0        0      sky130_fd_pr__nfet_01v8  W=1 L=0.15
*
* ── Simulation ──────────────────────────────────────────────────────
* Active: DC  →  sky130_inv.raw
.control
dc Vin 0 1.8 0.05
write sky130_inv.raw
quit
.endc
*
* Other analyses (uncomment to use):
* .op ...
* .tran ...
* .ac ...
* .noise ...
*
.end
