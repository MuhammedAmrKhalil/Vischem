* active_cascode
* Generated by Vischem v0.1 — NGspice ready
*
* ── Models ──────────────────────────────────────────────────────────
.include "C:/Users/mamr2/OneDrive/Desktop/vischem/examples/models/ee214b.sp"
*
* ── Netlist ──
M2         N003     N001     VDD      VDD    pch  W=20u L=1u
M3         Vout     N002     N003     VDD    pch  W=20u L=1u
M4         N001     N001     VDD      VDD    pch  W=20u L=1u
M5         N002     N002     N001     VDD    pch  W=20u L=1u
M6         Vout     N002     N007     0      nch  W=10u L=1u
M7         N007     N006     0        0      nch  W=10u L=1u
M8         N002     N002     N004     0      nch  W=10u L=1u
M9         N004     N004     0        0      nch  W=10u L=1u
R1         N004     N006     1e6
C2         N006     N005     1u
V1         N005     0        DC 0 AC 1 SIN(0 1 1k 0 0 0)
V2         VDD      0        DC 2.5
C3         Vout     0        1p
*
* ── Simulation ──────────────────────────────────────────────────────
* Active: DC  →  active_cascode.raw
.control
dc V1 0 5 0.1
write active_cascode.raw
quit
.endc
*
* Other analyses (uncomment to use):
* .op ...
* .tran ...
* .ac ...
* .noise ...
*
.end
