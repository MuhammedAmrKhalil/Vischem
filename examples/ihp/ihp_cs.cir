* Vischem
* Generated by Vischem v0.1 — NGspice ready
*
* ── Models ──────────────────────────────────────────────────────────
* ── IHP SG13G2 (130nm BiCMOS) Models ──────────────────────────
.lib "/home/ziad/pdk/ihp-sg13g2/libs.tech/ngspice/models/cornerMOSlv.lib" mos_tt
.lib "/home/ziad/pdk/ihp-sg13g2/libs.tech/ngspice/models/cornerHBT.lib" hbt_typ
*
* ── Warnings ──
* [!] Floating pin: Rd pin 'p' at (5,2)
* [!] Floating pin: Rd pin 'n' at (7,2)
*
* ── Netlist ──
Vdd        N001     0        DC 1
Vin        N002     0        DC 1
XM1        N003     N002     0        0      sg13_lv_nmos  W=2.0u L=0.45u
Rd         N005     N004     5k
*
* ── Simulation ──────────────────────────────────────────────────────
* Active: DC  →  ihp_cs.raw
.control
dc Vin 0 1.5 0.01
write ihp_cs.raw
quit
.endc
*
* Other analyses (uncomment to use):
* .op ...
* .tran ...
* .ac ...
* .noise ...
*
.end
